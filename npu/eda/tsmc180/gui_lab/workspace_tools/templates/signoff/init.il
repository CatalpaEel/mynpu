tf=techOpenTechFile("mynpu_tech2000" "tech.db" "a")
unless(tf error("Cannot open local technology copy"))
unless(techSetDBUPerUU(tf "maskLayout" 2000.0) error("Cannot set local precision"))
techSaveTechFile(tf)
techCloseTechFile(tf)
ddCreateLib("mynpu_lab5_exact" "/home/s2400012841/chip-fullstack-2026/eda-runs/20261118-main53655b5-lab5-r1/workspace/mynpu_lab5_exact")
techBindTechFile(ddGetObj("mynpu_lab5_exact") "mynpu_tech2000")
f=outfile("/home/s2400012841/chip-fullstack-2026/eda-runs/20261118-main53655b5-lab5-r1/outputs/exact_technology.txt")
fprintf(f "local=%L shared=%L\n" techGetDBUPerUU(techGetTechFile(ddGetObj("mynpu_tech2000")) "maskLayout") techGetDBUPerUU(techGetTechFile(ddGetObj("tsmc18")) "maskLayout"))
close(f)
printf("LAB5_EXACT_TECH_PASS\n")
exit()
