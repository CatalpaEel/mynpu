ddCreateLib("mynpu_lab5_final" "/home/s2400012841/chip-fullstack-2026/eda-runs/20261118-main53655b5-lab5-r1/workspace/mynpu_lab5_final")
techBindTechFile(ddGetObj("mynpu_lab5_final") "mynpu_tech2000")
exit()
